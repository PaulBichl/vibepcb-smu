* SMU control loop with TI's vendor models (run ./fetch_models.sh first; ngspice reads
* .spiceinit = PSpice compatibility). Same topology and parameters as loop.cir:
* Vout(S+ - S-) = 30 V - 24*VSET, current limit +-ISET/2 [A], INA828 G = 1 + 50k/5.6k.
* Rails: firmware tracks them (V+ = Vout_max + 4 V >= 4.5 V, V- = Vout_min - 4 V <= -5 V);
* set vpr / vnr per case (span <= 52 V, OPA548 max 60 V).
.include vendor/OPA548.LIB
.include vendor/INA828.LIB
.include vendor/OPAx192.LIB
.include models.inc
.param vset=0.8333 iset=2 rl=20 vset2=vset tstep=1 cf=4.7n cint=47n rz=12k ri=10k rc=10k
.param vpr=34 vnr=-18 rcl=49.9k riso=0.47
VP vplus 0 {vpr}
VN vminus 0 {vnr}
VA5 va5 0 5
VAN van 0 -4.35
VREFN refn 0 -2.5
VS vsetn 0 PWL(0 {vset} {tstep} {vset} {tstep+1e-6} {vset2}) AC 1
VI isetn 0 {iset}
* ---- power stage (R100/R101 || -> 5k, R102 from REFN, R103 feedback, C104 HF feedback)
Rin vsetn n 5k
Roff refn n 10k
Rf splus n 120k
Cf out n {cf}
Rpa sminus p 120k
Rpb p 0 3.3333k
* OPA548: ILIM through R109 to V-, E/S open (enabled)
XPA p n ilim vminus vplus out es OPA548
RCL ilim vminus {rcl}
Res es 0 1e12
* Riso: isolates the OPA548 from the output capacitance (C108 + load); without it the amp
* oscillates into 1 uF (TI model). C104 keeps the fast feedback on the amp side.
Riso out ro {riso}
Rrly ro hi 0.05
Rsp hi splus 100
Rsl out splus 4.7k
Rsm lo sminus 100
* ---- load + shunt (C108 1 uF across the terminals)
RL hi lo {rl}
CL hi lo 1u
Rs lo 0 0.1
* ---- INA828, IN+ on GND, IN- on LO: vi = -9.93 V/A
XINA 0 lo va5 van vi 0 rg1 rg2 INA828
RG rg1 rg2 5.6k
* ---- thresholds: ISET straight, -ISET from U32B (ideal here)
Bthn isetneg 0 V=-V(isetn)
* ---- positive limit
Ria vi a {ri}
Rta isetn a {2*ri}
Ca a cpa {cint}
Rza cpa outp {rz}
XP 0 a va5 van outp OPAx192
Dcp a outp D1N4148
Dop outp dpo D1N4148
Rcp dpo n {rc}
* ---- negative limit
Rib vi b {ri}
Rtb isetneg b {2*ri}
Cb b cpb {cint}
Rzb cpb outn {rz}
XN 0 b va5 van outn OPAx192
Dcn outn b D1N4148
Don dno outn D1N4148
Rcn n dno {rc}
.end
